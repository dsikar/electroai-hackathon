.TITLE reverse_engineered_schematic
V1 N2 N3 DC 15
R1 N1 N2 3
R2 N1 0 14
R3 N2 0 5
R4 N3 0 4
.END
