* Bridge Rectifier
V1 AC_TOP AC_BOT SINE(0 170 60)
D1 AC_TOP DC_PLUS D
D2 DC_MINUS AC_TOP D
D3 AC_BOT DC_PLUS D
D4 DC_MINUS AC_BOT D
R1 DC_PLUS DC_MINUS 1k
.model D D
.tran 0 0.1 0 1m
.end
